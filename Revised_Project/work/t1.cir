* test
M1 d g 0 0 NWS l=3u w=3u
Q1 c b 0 NPN
VB b 0 0.7
VC c 0 2
VGS g 0 2
VDS d 0 3
R1 c 0 10k tc1=1.56e-3 tc2=6.1e-7
.include EE4323_cmos.mos
.include standard.bjt
.op
.end
